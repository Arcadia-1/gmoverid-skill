simulator lang=spectre

subckt ota_5t vss vbias vdd vinn vinp vout
XN1 (nleft vinp tail vss) sky130_fd_pr__nfet_01v8 l=0.5 w=8 nf=1
XN2 (vout vinn tail vss) sky130_fd_pr__nfet_01v8 l=0.5 w=8 nf=1
XP3 (nleft nleft vdd vdd) sky130_fd_pr__pfet_01v8 l=0.5 w=16 nf=1
XP4 (vout nleft vdd vdd) sky130_fd_pr__pfet_01v8 l=0.5 w=16 nf=1
XN5 (tail vbias vss vss) sky130_fd_pr__nfet_01v8 l=0.5 w=16 nf=1
ends ota_5t
