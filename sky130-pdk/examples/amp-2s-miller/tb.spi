* Sky130A two-stage Miller amplifier standalone open-loop AC testbench.
.lib "$PDK_ROOT/sky130A/libs.tech/combined/continuous/sky130.lib.spice" tt
.include "circuit.spi"
.options method=gear reltol=2e-3 abstol=1e-12 vntol=1e-6 chgtol=1e-15
.param vddval=1.8 vcm=0.9 vbiasval=0.72

VSS vss 0 DC 0
VDD vdd vss DC {vddval}
VBIAS vbias vss DC {vbiasval}
VIP vinp vss DC {vcm} AC 0.5
VIN vinn vss DC {vcm} AC -0.5
XAMP vss vbias vdd vinn vinp vout amp_2s_miller
CL vout vss 500f

.ac dec 60 1 1e9
.meas ac gain10_v FIND vm(vout) AT=10
.meas ac gain10_db FIND vdb(vout) AT=10
.meas ac gain1k_v FIND vm(vout) AT=1k
.meas ac gain1k_db FIND vdb(vout) AT=1k

.control
run
quit
.endc
.end
