* VSS ripple to output gain for PSRR-.
.lib "$PDK_ROOT/sky130A/libs.tech/combined/continuous/sky130.lib.spice" tt
.include "five_transistor_ota.spi"
.save v(vout)
.param VDDVAL=1.8 VIC=0.9 VBIAS=0.72 CL=100f

XOTA vss vbias vdd vinn vinp vout five_transistor_ota
VVSS vss 0 0 AC 1
VDD vdd vss {VDDVAL}
VBIAS vbias vss {VBIAS}
VINP vinp vss {VIC}
VINN vinn vss {VIC}
CLOAD vout vss {CL}

.ac dec 40 1 1e9
.meas ac avss_10hz_db FIND vdb(vout) AT=10
.meas ac avss_1k_db FIND vdb(vout) AT=1k
.end
