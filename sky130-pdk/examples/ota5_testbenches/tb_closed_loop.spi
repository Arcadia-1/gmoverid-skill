* Unity-gain follower transient response.
.lib "$PDK_ROOT/sky130A/libs.tech/combined/continuous/sky130.lib.spice" tt
.include "five_transistor_ota.spi"
.param VDDVAL=1.8 VIC=0.9 VSTEP=0.05 VBIAS=0.72 CL=100f

XOTA 0 vbias vdd vinn vinp vout five_transistor_ota
VDD vdd 0 {VDDVAL}
VBIAS vbias 0 {VBIAS}
VINP vinp 0 PULSE({VIC} {VIC+VSTEP} 20n 20p 20p 80n 200n)
EFB vinn 0 vout 0 1
CLOAD vout 0 {CL}

.tran 50p 180n
.meas tran vout_before FIND v(vout) AT=19n
.meas tran vout_final FIND v(vout) AT=170n
.meas tran vout_max MAX v(vout) FROM=20n TO=170n
.end
