* Bias-voltage sweep.
.lib "$PDK_ROOT/sky130A/libs.tech/combined/continuous/sky130.lib.spice" tt
.include "five_transistor_ota.spi"
.param VDDVAL=1.8 VIC=0.9 CL=100f

XOTA 0 vbias vdd vinn vinp vout five_transistor_ota
VDD vdd 0 {VDDVAL}
VBIAS vbias 0 0.72
VINP vinp 0 {VIC} AC 0.5
VINN vinn 0 {VIC} AC -0.5
CLOAD vout 0 {CL}

.dc VBIAS 0.55 0.9 0.01
.meas dc vout_bias_0p6 FIND v(vout) AT=0.6
.meas dc vout_bias_0p72 FIND v(vout) AT=0.72
.meas dc vout_bias_0p85 FIND v(vout) AT=0.85
.end
