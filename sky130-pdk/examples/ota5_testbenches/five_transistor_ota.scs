simulator lang=spectre

// Differential input, single-ended output five-transistor OTA.
// Ports: VSS VBIAS VDD VINN VINP VOUT
subckt five_transistor_ota vss vbias vdd vinn vinp vout
    XN1 (left vinp tail vss) sky130_fd_pr__nfet_01v8 l=0.5 w=8 nf=1
    XN2 (vout vinn tail vss) sky130_fd_pr__nfet_01v8 l=0.5 w=8 nf=1
    XP3 (left left vdd vdd) sky130_fd_pr__pfet_01v8 l=0.5 w=16 nf=1
    XP4 (vout left vdd vdd) sky130_fd_pr__pfet_01v8 l=0.5 w=16 nf=1
    XN5 (tail vbias vss vss) sky130_fd_pr__nfet_01v8 l=0.5 w=16 nf=1
ends five_transistor_ota
