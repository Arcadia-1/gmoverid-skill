* Open-loop five-transistor OTA gain and noise run.
.lib "$PDK_ROOT/sky130A/libs.tech/combined/continuous/sky130.lib.spice" tt
.include "five_transistor_ota.spi"
.save all
.param VDDVAL=1.8 VIC=0.9 VBIAS=0.72 CL=100f

XOTA 0 vbias vdd vinn vinp vout five_transistor_ota
VDD vdd 0 {VDDVAL}
VBIAS vbias 0 {VBIAS}
VINP vinp 0 {VIC} AC 0.5
VINN vinn 0 {VIC} AC -0.5
CLOAD vout 0 {CL}

.op
.ac dec 40 1 1e9
.noise v(vout) VINP dec 20 1 1e6
.meas ac gain10_db FIND vdb(vout) AT=10
.meas ac gain1k_db FIND vdb(vout) AT=1k
.meas ac unity_hz WHEN vm(vout)=1
.end
