simulator lang=spectre
parameters VDDVAL=1.8 VIC=0.9 CL=100f
include "sky130.lib.spice" section=tt
include "five_transistor_ota.scs"

X_OTA (VSS VBIAS_N VDD VINN VINP VOUT) five_transistor_ota
V_vss (VSS 0) vsource dc=0 type=dc
V_vdd (VDD VSS) vsource dc=VDDVAL type=dc
V_bias (VBIAS_N VSS) vsource dc=0.72 type=dc
Vinp (VINP VSS) vsource dc=VIC mag=0.5 type=dc
Vinn (VINN VSS) vsource dc=VIC mag=-0.5 type=dc
C_load (VOUT VSS) capacitor c=CL
dc1 dc source=V_bias start=0.55 stop=0.9 step=0.01
