* Input common-mode range sweep.
.lib "$PDK_ROOT/sky130A/libs.tech/combined/continuous/sky130.lib.spice" tt
.include "five_transistor_ota.spi"
.param VDDVAL=1.8 VBIAS=0.72 CL=100f

XOTA 0 vbias vdd vinn vinp vout five_transistor_ota
VDD vdd 0 {VDDVAL}
VBIAS vbias 0 {VBIAS}
VCM vcm 0 0.9
EVINP vinp 0 vcm 0 1
EVINN vinn 0 vcm 0 1
CLOAD vout 0 {CL}

.dc VCM 0.1 1.6 0.05
.meas dc vout_vcm_0p3 FIND v(vout) AT=0.3
.meas dc vout_vcm_0p9 FIND v(vout) AT=0.9
.meas dc vout_vcm_1p5 FIND v(vout) AT=1.5
.end
