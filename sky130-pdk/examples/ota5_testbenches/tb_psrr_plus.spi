* VDD ripple to output gain for PSRR+.
.lib "$PDK_ROOT/sky130A/libs.tech/combined/continuous/sky130.lib.spice" tt
.include "five_transistor_ota.spi"
.save v(vout)
.param VDDVAL=1.8 VIC=0.9 VBIAS=0.72 CL=100f

XOTA 0 vbias vdd vinn vinp vout five_transistor_ota
VDD vdd 0 {VDDVAL} AC 1
VBIAS vbias 0 {VBIAS}
VINP vinp 0 {VIC}
VINN vinn 0 {VIC}
CLOAD vout 0 {CL}

.ac dec 40 1 1e9
.meas ac avdd_10hz_db FIND vdb(vout) AT=10
.meas ac avdd_1k_db FIND vdb(vout) AT=1k
.end
