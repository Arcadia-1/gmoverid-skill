* Sky130A ring oscillator standalone transient testbench.
.lib "$PDK_ROOT/sky130A/libs.tech/combined/continuous/sky130.lib.spice" tt
.include "circuit.spi"
.options method=gear reltol=2e-3 abstol=1e-12 vntol=1e-6 chgtol=1e-15
.param vddval=1.8

VDD vdd 0 DC {vddval}
XRO vdd 0 out tap1 tap2 ring_oscillator
COUT out 0 2f
CT1 tap1 0 2f
CT2 tap2 0 2f

.ic v(out)=0 v(tap1)=1.8 v(tap2)=0.6
.tran 2p 6n 0 4p uic
.meas tran t5 WHEN v(out)=0.9 RISE=5
.meas tran t12 WHEN v(out)=0.9 RISE=12
.meas tran period PARAM='(t12-t5)/7'
.meas tran freq_hz PARAM='1/period'

.control
run
quit
.endc
.end
