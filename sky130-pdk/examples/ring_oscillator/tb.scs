simulator lang=spectre
include "sky130.lib.spice" section=tt
include "circuit.scs"
options method=gear reltol=2e-3 abstol=1e-12 vntol=1e-6 chgtol=1e-15
parameters vddval=1.8

VDD (vdd 0) vsource dc=vddval
XRO (vdd 0 out tap1 tap2) ring_oscillator
COUT (out 0) capacitor c=2f
CT1 (tap1 0) capacitor c=2f
CT2 (tap2 0) capacitor c=2f

ic out=0 tap1=1.8 tap2=0.6
tran1 tran step=2p stop=6n maxstep=4p uic=yes
measure tran t5 WHEN v(out)=0.9 RISE=5
measure tran t12 WHEN v(out)=0.9 RISE=12
measure tran period PARAM='(t12-t5)/7'
measure tran freq_hz PARAM='1/period'
