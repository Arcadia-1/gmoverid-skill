* Sky130A ngspice 3-stage ring oscillator example.
.lib "$PDK_ROOT/sky130A/libs.tech/combined/continuous/sky130.lib.spice" tt
.options method=gear reltol=2e-3 abstol=1e-12 vntol=1e-6 chgtol=1e-15
.save v(n1) v(n2) v(n3)
.param vdd=1.8

VDD vdd 0 {vdd}

.subckt inv in out vdd vss
XP out in vdd vdd sky130_fd_pr__pfet_01v8 l=0.15 w=1.26 nf=1
XN out in vss vss sky130_fd_pr__nfet_01v8 l=0.15 w=0.42 nf=1
.ends inv

XINV0 n3 n1 vdd 0 inv
XINV1 n1 n2 vdd 0 inv
XINV2 n2 n3 vdd 0 inv

C1 n1 0 2f
C2 n2 0 2f
C3 n3 0 2f

.ic v(n1)=0 v(n2)=1.8 v(n3)=0.6
.tran 2p 6n 0 4p uic
.meas tran t5 WHEN v(n1)=0.9 RISE=5
.meas tran t12 WHEN v(n1)=0.9 RISE=12
.meas tran period PARAM='(t12-t5)/7'
.meas tran freq_hz PARAM='1/period'
.end
